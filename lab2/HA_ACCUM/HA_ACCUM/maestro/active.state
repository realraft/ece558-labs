ADE simulation setup
Test HA_ACCUM_HA_ACCUM_1: HA_ACCUM/HA_ACCUM/schematic, simulator hspiceD
Run mode: Single Run, Sweeps and Corners
