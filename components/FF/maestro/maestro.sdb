ADE simulation setup
Run mode: Single Run, Sweeps and Corners
Tests:
  components_FF_1: components/FF/schematic, simulator hspiceD
