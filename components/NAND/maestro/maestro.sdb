ADE simulation setup
Run mode: Single Run, Sweeps and Corners
Tests:
  NAND_X1_NAND_X1_1: NAND_X1/NAND_X1/schematic, simulator hspiceD
