ADE simulation setup
Run mode: Single Run, Sweeps and Corners
Tests:
  components_HA_1: components/HA/schematic, simulator hspiceD
