ADE simulation setup
Test components_HA_1: components/HA/schematic, simulator hspiceD
Run mode: Single Run, Sweeps and Corners
