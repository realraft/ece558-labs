ADE simulation setup
Test components_XOR_1: components/XOR/schematic, simulator hspiceD
Run mode: Single Run, Sweeps and Corners
