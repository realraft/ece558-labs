ADE simulation setup
Run mode: Single Run, Sweeps and Corners
Tests:
  components_XOR_1: components/XOR/schematic, simulator hspiceD
