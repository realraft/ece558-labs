ADE simulation setup
Run mode: Single Run, Sweeps and Corners
Tests:
  components_AND_1: components/AND/schematic, simulator hspiceD
