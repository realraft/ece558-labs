ADE simulation setup
Test components_AND_1: components/AND/schematic, simulator hspiceD
Run mode: Single Run, Sweeps and Corners
