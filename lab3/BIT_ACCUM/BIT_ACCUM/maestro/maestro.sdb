ADE simulation setup
Run mode: Single Run, Sweeps and Corners
Tests:
  BIT_ACCUM_BIT_ACCUM_1: BIT_ACCUM/BIT_ACCUM/schematic, simulator hspiceD
