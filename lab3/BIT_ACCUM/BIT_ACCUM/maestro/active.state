ADE simulation setup
Test BIT_ACCUM_BIT_ACCUM_1: BIT_ACCUM/BIT_ACCUM/schematic, simulator hspiceD
Run mode: Single Run, Sweeps and Corners
