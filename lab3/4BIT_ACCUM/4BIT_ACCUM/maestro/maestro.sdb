ADE simulation setup
Run mode: Single Run, Sweeps and Corners
Tests:
  4BIT_ACCUM_4BIT_ACCUM_1: 4BIT_ACCUM/4BIT_ACCUM/schematic, simulator hspiceD
